*// Transient Simulation //*
********************************************************************************
* Mon Oct 12 2026 10:14:53 GMT+0800 (中国标准时间)
*
* Texas Instruments Incorporated
* ASC-INT-LOGIC
* 12500 TI Blvd
* Dallas, TX 75243
*
* Automated model revision history:
* Rev 1.0: [[RELEASE DATE]]
* - Initial version
*
********************************************************************************
*[Disclaimer]
* This model is designed as an aid for customers of Texas Instruments.
* TI and its licensors and suppliers make no warranties, either expressed
* or implied, with respect to this  model, including the warranties of
* merchantability or fitness for a particular purpose. The model is
* provided solely on an "as is" basis. The entire risk as to its quality
* and performance is with the customer.
*
*[Copyright]
*(C) Copyright 2026 Texas Instruments Incorporated. All rights reserved.
********************************************************************************
*// This file generated by InterConnect Studio for simulation with ngspice //*
.include "C:\ti\interconnectstudio_1.8.0\product\source\ti\tpld\.meta\templates\subcircuits\prim_cells_ngspice.mod"
.include "C:\ti\interconnectstudio_1.8.0\product\source\ti\tpld\.meta\templates\subcircuits\dff_ngspice.mod"
.include "C:\ti\interconnectstudio_1.8.0\product\source\ti\tpld\.meta\templates\subcircuits\dff_sr8.mod"
.include "C:\ti\interconnectstudio_1.8.0\product\source\ti\tpld\.meta\templates\subcircuits\dff2_tpld1202.mod"
.include "C:\ti\interconnectstudio_1.8.0\product\source\ti\tpld\.meta\templates\subcircuits\cntr.mod"
.include "C:\ti\interconnectstudio_1.8.0\product\source\ti\tpld\.meta\templates\subcircuits\cntr_dly_1202.mod"
.include "C:\ti\interconnectstudio_1.8.0\product\source\ti\tpld\.meta\templates\subcircuits\pwm.mod"
.include "C:\ti\interconnectstudio_1.8.0\product\source\ti\tpld\.meta\templates\subcircuits\pdly.mod"
.include "C:\ti\interconnectstudio_1.8.0\product\source\ti\tpld\.meta\templates\subcircuits\wdt.mod"
.include "C:\ti\interconnectstudio_1.8.0\product\source\ti\tpld\.meta\templates\subcircuits\asm.mod"
.include "C:\ti\interconnectstudio_1.8.0\product\source\ti\tpld\.meta\templates\subcircuits\pgen.mod"
.include "C:\ti\interconnectstudio_1.8.0\product\source\ti\tpld\.meta\templates\subcircuits\mcacmp.mod"
.func if(a,b,c) 'ternary_fcn( a , b , c )'
.options trtol=1

* system

* CAPACITOR HANDLING

* RESISTOR HANDLING

* INDUCTOR HANDLING

* DIODE HANDLING

* SCHOTTKY DIODE HANDLING

* ZENER DIODE HANDLING

* NPN BJT HANDLING

* PNP BJT HANDLING

* NMOS HANDLING

* PMOS HANDLING

* VOLTAGE SOURCE HANDLING

* CURRENT SOURCE HANDLING

* VCC HANDLING

* TPLD HANDLING
X_dynamic0 VCC0_OUT 0 Input_IN_EXT_dynamic0 Green_OUT_EXT_dynamic0 Red_OUT_EXT_dynamic0 Blue_OUT_EXT_dynamic0 pin0_OUT_EXT_dynamic0 TPLD2001_dynamic0

* $dynamic0
.SUBCKT TPLD2001_dynamic0 VDD GND Input_IN_dynamic0 Green_OUT_dynamic0 Red_OUT_dynamic0 Blue_OUT_dynamic0 pin0_OUT_dynamic0
*// This is the auto-power-on signal for the oscillator
*// by default it is off (A_OUT_ON = 0V)
*// Any module can pull the node HIGH to activate
RAUTO_ON A_AUTO_ON A_ZERO 1k
AAUTO_ON [A_AUTO_ON] [D_AUTO_ON] adc_ideal

*// Used for preventing floating nodes
R101 error1 GND 1k
R102 error2 GND 1k
R103 error3 GND 1k
R104 error4 GND 1k

EROH1X ROH1X GND TABLE {V(VDD)} =
+ (1.8,61)
+ (3.3,50)
+ (5,37)
EROL1X ROL1X GND TABLE {V(VDD)} =
+ (1.8,18)
+ (3.3,14)
+ (5,9)
EROH2X ROH2X GND TABLE {V(VDD)} =
+ (1.8,31)
+ (3.3,25)
+ (5,18)
EROL2X ROL2X GND TABLE {V(VDD)} =
+ (1.8,7)
+ (3.3,6)
+ (5,4)

*// ACMP //*

*// AMUX //*

*// MCACMP //*

*// BANDGAP //*

*// CNT //*
R_cnt0_FORCE_PWRON A_AUTO_ON A_ONE 1
X_cnt0 D_STARTUP D_ZERO D__cnt3_OUT D_ZERO D__2MHz0_OSC1_DIV64
+ D_ONE D_ONE D_ONE D_ONE D_ONE D_ONE D_ONE D_ONE
+ D_ZERO D_ZERO D_ONE D_ONE D_ZERO D_ZERO D_ZERO D_ZERO D_ZERO D_ZERO D_ZERO
+ edge_sel0_cnt0 edge_sel1_cnt0 edge_in_o__cnt0 D_ZERO dat0_CNT6_FSM0 dat1_CNT6_FSM0 dat2_CNT6_FSM0 dat3_CNT6_FSM0 dat4_CNT6_FSM0
+ dat5_CNT6_FSM0 dat6_CNT6_FSM0 dat7_CNT6_FSM0 D_CNT6_FSM0_OUT cntr_dly_1202
A_DAC_0__cnt0 [D_CNT6_FSM0_OUT] [A_cnt0_0] dac_ideal
R0_cnt0 A_cnt0_0 A_cnt0_DEL 5k
C0_cnt0 A_cnt0_DEL 0 425f
AHYST_0__cnt0 A_cnt0_DEL A__cnt0_HYST hyst_pdly
A_ADC_0__cnt0 [A__cnt0_HYST] [D__cnt0_OUT] adc_ideal
R_cnt1_FORCE_PWRON A_AUTO_ON A_ONE 1
X_cnt1 D_STARTUP D_ZERO D__cnt4_OUT D_ZERO D__2MHz0_OSC1_DIV64
+ D_ONE D_ONE D_ONE D_ONE D_ONE D_ONE D_ONE D_ONE
+ D_ZERO D_ZERO D_ONE D_ONE D_ZERO D_ZERO D_ZERO D_ZERO D_ZERO D_ZERO D_ZERO
+ edge_sel0_cnt1 edge_sel1_cnt1 edge_in_o__cnt1 D_ZERO dat0_CNT7_FSM1 dat1_CNT7_FSM1 dat2_CNT7_FSM1 dat3_CNT7_FSM1 dat4_CNT7_FSM1
+ dat5_CNT7_FSM1 dat6_CNT7_FSM1 dat7_CNT7_FSM1 D_CNT7_FSM1_OUT cntr_dly_1202
A_DAC_0__cnt1 [D_CNT7_FSM1_OUT] [A_cnt1_0] dac_ideal
R0_cnt1 A_cnt1_0 A_cnt1_DEL 5k
C0_cnt1 A_cnt1_DEL 0 425f
AHYST_0__cnt1 A_cnt1_DEL A__cnt1_HYST hyst_pdly
A_ADC_0__cnt1 [A__cnt1_HYST] [D__cnt1_OUT] adc_ideal
R_cnt2_FORCE_PWRON A_AUTO_ON A_ONE 1
X_cnt2 D_STARTUP D_ZERO D__cnt5_OUT D_ZERO D__2MHz0_OSC1_DIV64
+ D_ONE D_ONE D_ONE D_ONE D_ONE D_ONE D_ONE D_ONE
+ D_ZERO D_ZERO D_ONE D_ONE D_ZERO D_ZERO D_ZERO D_ZERO D_ZERO D_ZERO D_ZERO
+ edge_sel0_cnt2 edge_sel1_cnt2 edge_in_o__cnt2 D_ZERO dat0_CNT8_FSM2 dat1_CNT8_FSM2 dat2_CNT8_FSM2 dat3_CNT8_FSM2 dat4_CNT8_FSM2
+ dat5_CNT8_FSM2 dat6_CNT8_FSM2 dat7_CNT8_FSM2 D_CNT8_FSM2_OUT cntr_dly_1202
A_DAC_0__cnt2 [D_CNT8_FSM2_OUT] [A_cnt2_0] dac_ideal
R0_cnt2 A_cnt2_0 A_cnt2_DEL 5k
C0_cnt2 A_cnt2_DEL 0 425f
AHYST_0__cnt2 A_cnt2_DEL A__cnt2_HYST hyst_pdly
A_ADC_0__cnt2 [A__cnt2_HYST] [D__cnt2_OUT] adc_ideal
R_cnt3_FORCE_PWRON A_AUTO_ON A_ONE 1
X_cnt3 D_STARTUP D_ZERO D_ZERO D__lut0_OUT D__2MHz0_OSC1_DIV64
+ D_ZERO D_ONE D_ONE D_ONE D_ONE D_ONE D_ONE D_ONE
+ D_ONE D_ONE D_ONE D_ONE D_ZERO D_ZERO D_ZERO D_ZERO D_ZERO D_ZERO D_ZERO
+ edge_sel0_cnt3 edge_sel1_cnt3 edge_in_o__cnt3 D_ZERO dat0_LUT3_10 dat1_LUT3_10 dat2_LUT3_10 dat3_LUT3_10 dat4_LUT3_10
+ dat5_LUT3_10 dat6_LUT3_10 dat7_LUT3_10 D_LUT3_10_OUT cntr_dly_1202
A_DAC_0__cnt3 [D_LUT3_10_OUT] [A_cnt3_0] dac_ideal
R0_cnt3 A_cnt3_0 A_cnt3_DEL 5k
C0_cnt3 A_cnt3_DEL 0 425f
AHYST_0__cnt3 A_cnt3_DEL A__cnt3_HYST hyst_pdly
A_ADC_0__cnt3 [A__cnt3_HYST] [D__cnt3_OUT] adc_ideal
R_cnt4_FORCE_PWRON A_AUTO_ON A_ONE 1
X_cnt4 D_STARTUP D_ZERO D_ZERO D__lut1_OUT D__2MHz0_OSC1_DIV64
+ D_ZERO D_ONE D_ONE D_ONE D_ONE D_ONE D_ONE D_ONE
+ D_ONE D_ONE D_ONE D_ONE D_ZERO D_ZERO D_ZERO D_ZERO D_ZERO D_ZERO D_ZERO
+ edge_sel0_cnt4 edge_sel1_cnt4 edge_in_o__cnt4 D_ZERO dat0_LUT3_8 dat1_LUT3_8 dat2_LUT3_8 dat3_LUT3_8 dat4_LUT3_8
+ dat5_LUT3_8 dat6_LUT3_8 dat7_LUT3_8 D_LUT3_8_OUT cntr_dly_1202
A_DAC_0__cnt4 [D_LUT3_8_OUT] [A_cnt4_0] dac_ideal
R0_cnt4 A_cnt4_0 A_cnt4_DEL 5k
C0_cnt4 A_cnt4_DEL 0 425f
AHYST_0__cnt4 A_cnt4_DEL A__cnt4_HYST hyst_pdly
A_ADC_0__cnt4 [A__cnt4_HYST] [D__cnt4_OUT] adc_ideal
R_cnt5_FORCE_PWRON A_AUTO_ON A_ONE 1
X_cnt5 D_STARTUP D_ZERO D_ZERO D__lut2_OUT D__2MHz0_OSC1_DIV64
+ D_ZERO D_ONE D_ONE D_ONE D_ONE D_ONE D_ONE D_ONE
+ D_ONE D_ONE D_ONE D_ONE D_ZERO D_ZERO D_ZERO D_ZERO D_ZERO D_ZERO D_ZERO
+ edge_sel0_cnt5 edge_sel1_cnt5 edge_in_o__cnt5 D_ZERO dat0_CNT9_FSM3 dat1_CNT9_FSM3 dat2_CNT9_FSM3 dat3_CNT9_FSM3 dat4_CNT9_FSM3
+ dat5_CNT9_FSM3 dat6_CNT9_FSM3 dat7_CNT9_FSM3 D_CNT9_FSM3_OUT cntr_dly_1202
A_DAC_0__cnt5 [D_CNT9_FSM3_OUT] [A_cnt5_0] dac_ideal
R0_cnt5 A_cnt5_0 A_cnt5_DEL 5k
C0_cnt5 A_cnt5_DEL 0 425f
AHYST_0__cnt5 A_cnt5_DEL A__cnt5_HYST hyst_pdly
A_ADC_0__cnt5 [A__cnt5_HYST] [D__cnt5_OUT] adc_ideal

*// PWM //*
X_pwm0 D_STARTUP D__VCC0_OUT D__2MHz0_OSC1_DIV64
+ dat0_CNT6_FSM0 dat1_CNT6_FSM0 dat2_CNT6_FSM0 dat3_CNT6_FSM0 dat4_CNT6_FSM0 dat5_CNT6_FSM0 dat6_CNT6_FSM0 dat7_CNT6_FSM0
+ D_ZERO D_ZERO D_ZERO D_ZERO D__pwm0_OUT0 D__pwm0_OUT1 pwm
X_pwm1 D_STARTUP D__VCC0_OUT D__2MHz0_OSC1_DIV64
+ dat0_CNT7_FSM1 dat1_CNT7_FSM1 dat2_CNT7_FSM1 dat3_CNT7_FSM1 dat4_CNT7_FSM1 dat5_CNT7_FSM1 dat6_CNT7_FSM1 dat7_CNT7_FSM1
+ D_ZERO D_ZERO D_ZERO D_ZERO D__pwm1_OUT0 D__pwm1_OUT1 pwm
X_pwm2 D_STARTUP D__VCC0_OUT D__2MHz0_OSC1_DIV64
+ dat0_CNT8_FSM2 dat1_CNT8_FSM2 dat2_CNT8_FSM2 dat3_CNT8_FSM2 dat4_CNT8_FSM2 dat5_CNT8_FSM2 dat6_CNT8_FSM2 dat7_CNT8_FSM2
+ D_ZERO D_ZERO D_ZERO D_ZERO D__pwm2_OUT0 D__pwm2_OUT1 pwm

*// PGEN //*

*// DFF //*
X_dff0 D_STARTUP D_ONE D__dff2_OUT D__Input_OUT D_ZERO D_ZERO D_ZERO D_ZERO D_ONE D_ZERO D_ZERO D__dff0_OUT dff2_tpld1202
X_dff1 D_STARTUP D_ONE D__dff0_OUT D__Input_OUT D_ZERO D_ZERO D_ZERO D_ZERO D_ZERO D_ZERO D_ZERO D__dff1_OUT dff2_tpld1202
X_dff2 D_STARTUP D_ONE D__dff1_OUT D__Input_OUT D_ZERO D_ZERO D_ZERO D_ZERO D_ZERO D_ZERO D_ZERO D__dff2_OUT dff2_tpld1202

*// SR //*

*// Edge Detect //*

*// One-Shot //*

*// Frequency Detect //*

*// DLY //*

*// ASM //*

*// WDT //*

*// FILTER //*

*// GND //*
VA_ZERO A_ZERO GND 0
ABRIDGE_DZERO [A_ZERO] [D_ZERO] adc_ideal

*// LUT //*
ABUF_lut0_A D__Input_OUT D__lut0_A buf_ideal
ABUF_lut0_B D__dff0_OUT D__lut0_B buf_ideal
ALUT2__lut0 [D__lut0_A D__lut0_B] D__lut0_OUT LUT2__lut0
.model LUT2__lut0 d_lut(table_values="111011101110111" input_load=1e-15 rise_delay=27.5n fall_delay=27.5n)
ABUF_lut1_A D__Input_OUT D__lut1_A buf_ideal
ABUF_lut1_B D__dff1_OUT D__lut1_B buf_ideal
ALUT2__lut1 [D__lut1_A D__lut1_B] D__lut1_OUT LUT2__lut1
.model LUT2__lut1 d_lut(table_values="111011101110111" input_load=1e-15 rise_delay=27.5n fall_delay=27.5n)
ABUF_lut2_A D__Input_OUT D__lut2_A buf_ideal
ABUF_lut2_B D__dff2_OUT D__lut2_B buf_ideal
ALUT2__lut2 [D__lut2_A D__lut2_B] D__lut2_OUT LUT2__lut2
.model LUT2__lut2 d_lut(table_values="111011101110111" input_load=1e-15 rise_delay=27.5n fall_delay=27.5n)

*// OSC //*

*// OSC0 //*

*// OSC1 //*

*// OSC2 //*
.model osc_dly_2MHz0 d_buffer(rise_delay=1.23e-7 fall_delay=1.23e-7 input_load=1e-15)
.model osc_su_dly_2MHz0 d_buffer(rise_delay=1.3e-6 fall_delay=1e-9 input_load=1e-15)
A_2MHz0_finishbuf D_ONE D__2MHz0_FINISH buf_del_1ns
A_2MHz0_or1 [D_AUTO_ON D_ZERO] D__2MHz0_PUPOR or_del_1ns
A_2MHz0_andpor [D_STARTUP D__2MHz0_PUPOR] D__2MHz0_PUPORAND and_del_1ns
A_2MHz0_su_dly D__2MHz0_PUPORAND D__2MHz0_PUP_DEL osc_su_dly_2MHz0
A_2MHz0_and2 [D__2MHz0_FINISH D__2MHz0_DFF_OUT] D__2MHz0_FINISHSIG and_del_1ns
A_2MHz0_or2 [D__2MHz0_PUP_DEL D__2MHz0_FINISHSIG] D__2MHz0_PUPOR2 or_del_1ns
A_2MHz0_and1 [D__2MHz0_FB D__2MHz0_PUPOR2] D__2MHz0_OSC_INT and_del_1ns
A_2MHz0_osc_dly D__2MHz0_OSC_INT D__2MHz0_DELAYED osc_dly_2MHz0
A_2MHz0_osc_inv D__2MHz0_DELAYED D__2MHz0_FB inv_del_1ns
A_2MHz0_osc_dff D__2MHz0_DFF_QBAR D__2MHz0_OSC_INT D_ZERO D_ZERO D__2MHz0_DFF_OUT D__2MHz0_DFF_QBAR dff_ideal
A_2MHz0_osc_link D__2MHz0_DFF_OUT D__2MHz0_OSC buf_ideal
A_2MHz0_OUT0 D__2MHz0_OSC D__2MHz0_OUT0 buf_ideal
A_2MHz0_OUT1 D__2MHz0_OSC D__2MHz0_OUT1 buf_ideal
A_2MHz0_OSC2_DIV1 D__2MHz0_OSC D__2MHz0_OSC2_DIV1 buf_ideal
A_2MHz0_OSC2_DIV4 D__2MHz0_OSC D__2MHz0_OSC2_DIV4_MULT2 div_OSC2_DIV4_2MHz0
.model div_OSC2_DIV4_2MHz0 d_fdiv(div_factor=2 high_cycles=1 i_count=0 rise_delay=1e-12 fall_delay=1e-12)
A_2MHz0_DFF_OSC2_DIV4 D__2MHz0_OSC2_DIV4_Q_BAR D__2MHz0_OSC2_DIV4_MULT2 D_ZERO D_ZERO D__2MHz0_OSC2_DIV4 D__2MHz0_OSC2_DIV4_Q_BAR dff_ideal
A_2MHz0_OSC1_DIV1 D__2MHz0_OSC D__2MHz0_OSC1_DIV1 buf_ideal
A_2MHz0_OSC1_DIV2 D__2MHz0_OSC1_DIV2_Q_BAR D__2MHz0_OSC D_ZERO D_ZERO D__2MHz0_OSC1_DIV2 D__2MHz0_OSC1_DIV2_Q_BAR dff_ideal
A_2MHz0_OSC1_DIV4 D__2MHz0_OSC D__2MHz0_OSC1_DIV4_MULT2 div_OSC1_DIV4_2MHz0
.model div_OSC1_DIV4_2MHz0 d_fdiv(div_factor=2 high_cycles=1 i_count=0 rise_delay=1e-12 fall_delay=1e-12)
A_2MHz0_DFF_OSC1_DIV4 D__2MHz0_OSC1_DIV4_Q_BAR D__2MHz0_OSC1_DIV4_MULT2 D_ZERO D_ZERO D__2MHz0_OSC1_DIV4 D__2MHz0_OSC1_DIV4_Q_BAR dff_ideal
A_2MHz0_OSC1_DIV8 D__2MHz0_OSC D__2MHz0_OSC1_DIV8_MULT2 div_OSC1_DIV8_2MHz0
.model div_OSC1_DIV8_2MHz0 d_fdiv(div_factor=4 high_cycles=1 i_count=0 rise_delay=1e-12 fall_delay=1e-12)
A_2MHz0_DFF_OSC1_DIV8 D__2MHz0_OSC1_DIV8_Q_BAR D__2MHz0_OSC1_DIV8_MULT2 D_ZERO D_ZERO D__2MHz0_OSC1_DIV8 D__2MHz0_OSC1_DIV8_Q_BAR dff_ideal
A_2MHz0_OSC1_DIV20 D__2MHz0_OSC D__2MHz0_OSC1_DIV20_MULT2 div_OSC1_DIV20_2MHz0
.model div_OSC1_DIV20_2MHz0 d_fdiv(div_factor=10 high_cycles=1 i_count=0 rise_delay=1e-12 fall_delay=1e-12)
A_2MHz0_DFF_OSC1_DIV20 D__2MHz0_OSC1_DIV20_Q_BAR D__2MHz0_OSC1_DIV20_MULT2 D_ZERO D_ZERO D__2MHz0_OSC1_DIV20 D__2MHz0_OSC1_DIV20_Q_BAR dff_ideal
A_2MHz0_OSC1_DIV40 D__2MHz0_OSC D__2MHz0_OSC1_DIV40_MULT2 div_OSC1_DIV40_2MHz0
.model div_OSC1_DIV40_2MHz0 d_fdiv(div_factor=20 high_cycles=1 i_count=0 rise_delay=1e-12 fall_delay=1e-12)
A_2MHz0_DFF_OSC1_DIV40 D__2MHz0_OSC1_DIV40_Q_BAR D__2MHz0_OSC1_DIV40_MULT2 D_ZERO D_ZERO D__2MHz0_OSC1_DIV40 D__2MHz0_OSC1_DIV40_Q_BAR dff_ideal
A_2MHz0_OSC1_DIV64 D__2MHz0_OSC D__2MHz0_OSC1_DIV64_MULT2 div_OSC1_DIV64_2MHz0
.model div_OSC1_DIV64_2MHz0 d_fdiv(div_factor=32 high_cycles=1 i_count=0 rise_delay=1e-12 fall_delay=1e-12)
A_2MHz0_DFF_OSC1_DIV64 D__2MHz0_OSC1_DIV64_Q_BAR D__2MHz0_OSC1_DIV64_MULT2 D_ZERO D_ZERO D__2MHz0_OSC1_DIV64 D__2MHz0_OSC1_DIV64_Q_BAR dff_ideal
A_2MHz0_OSC1_DIV512 D__2MHz0_OSC D__2MHz0_OSC1_DIV512_MULT2 div_OSC1_DIV512_2MHz0
.model div_OSC1_DIV512_2MHz0 d_fdiv(div_factor=256 high_cycles=1 i_count=0 rise_delay=1e-12 fall_delay=1e-12)
A_2MHz0_DFF_OSC1_DIV512 D__2MHz0_OSC1_DIV512_Q_BAR D__2MHz0_OSC1_DIV512_MULT2 D_ZERO D_ZERO D__2MHz0_OSC1_DIV512 D__2MHz0_OSC1_DIV512_Q_BAR dff_ideal
A_2MHz0_OSC0_DIV1 D__2MHz0_OSC D__2MHz0_OSC0_DIV1 buf_ideal
A_2MHz0_OSC0_DIV2 D__2MHz0_OSC0_DIV2_Q_BAR D__2MHz0_OSC D_ZERO D_ZERO D__2MHz0_OSC0_DIV2 D__2MHz0_OSC0_DIV2_Q_BAR dff_ideal
A_2MHz0_OSC0_DIV8 D__2MHz0_OSC D__2MHz0_OSC0_DIV8_MULT2 div_OSC0_DIV8_2MHz0
.model div_OSC0_DIV8_2MHz0 d_fdiv(div_factor=4 high_cycles=1 i_count=0 rise_delay=1e-12 fall_delay=1e-12)
A_2MHz0_DFF_OSC0_DIV8 D__2MHz0_OSC0_DIV8_Q_BAR D__2MHz0_OSC0_DIV8_MULT2 D_ZERO D_ZERO D__2MHz0_OSC0_DIV8 D__2MHz0_OSC0_DIV8_Q_BAR dff_ideal
A_2MHz0_OSC0_DIV64 D__2MHz0_OSC D__2MHz0_OSC0_DIV64_MULT2 div_OSC0_DIV64_2MHz0
.model div_OSC0_DIV64_2MHz0 d_fdiv(div_factor=32 high_cycles=1 i_count=0 rise_delay=1e-12 fall_delay=1e-12)
A_2MHz0_DFF_OSC0_DIV64 D__2MHz0_OSC0_DIV64_Q_BAR D__2MHz0_OSC0_DIV64_MULT2 D_ZERO D_ZERO D__2MHz0_OSC0_DIV64 D__2MHz0_OSC0_DIV64_Q_BAR dff_ideal
A_2MHz0_OSC0_DIV512 D__2MHz0_OSC D__2MHz0_OSC0_DIV512_MULT2 div_OSC0_DIV512_2MHz0
.model div_OSC0_DIV512_2MHz0 d_fdiv(div_factor=256 high_cycles=1 i_count=0 rise_delay=1e-12 fall_delay=1e-12)
A_2MHz0_DFF_OSC0_DIV512 D__2MHz0_OSC0_DIV512_Q_BAR D__2MHz0_OSC0_DIV512_MULT2 D_ZERO D_ZERO D__2MHz0_OSC0_DIV512 D__2MHz0_OSC0_DIV512_Q_BAR dff_ideal
A_2MHz0_OSC0_DIV4096 D__2MHz0_OSC D__2MHz0_OSC0_DIV4096_MULT2 div_OSC0_DIV4096_2MHz0
.model div_OSC0_DIV4096_2MHz0 d_fdiv(div_factor=2048 high_cycles=1 i_count=0 rise_delay=1e-12 fall_delay=1e-12)
A_2MHz0_DFF_OSC0_DIV4096 D__2MHz0_OSC0_DIV4096_Q_BAR D__2MHz0_OSC0_DIV4096_MULT2 D_ZERO D_ZERO D__2MHz0_OSC0_DIV4096 D__2MHz0_OSC0_DIV4096_Q_BAR dff_ideal
A_2MHz0_OSC0_DIV32768 D__2MHz0_OSC D__2MHz0_OSC0_DIV32768_MULT2 div_OSC0_DIV32768_2MHz0
.model div_OSC0_DIV32768_2MHz0 d_fdiv(div_factor=16384 high_cycles=1 i_count=0 rise_delay=1e-12 fall_delay=1e-12)
A_2MHz0_DFF_OSC0_DIV32768 D__2MHz0_OSC0_DIV32768_Q_BAR D__2MHz0_OSC0_DIV32768_MULT2 D_ZERO D_ZERO D__2MHz0_OSC0_DIV32768 D__2MHz0_OSC0_DIV32768_Q_BAR dff_ideal
A_2MHz0_OSC0_DIV262144 D__2MHz0_OSC D__2MHz0_OSC0_DIV262144_MULT2 div_OSC0_DIV262144_2MHz0
.model div_OSC0_DIV262144_2MHz0 d_fdiv(div_factor=131072 high_cycles=1 i_count=0 rise_delay=1e-12 fall_delay=1e-12)
A_2MHz0_DFF_OSC0_DIV262144 D__2MHz0_OSC0_DIV262144_Q_BAR D__2MHz0_OSC0_DIV262144_MULT2 D_ZERO D_ZERO D__2MHz0_OSC0_DIV262144 D__2MHz0_OSC0_DIV262144_Q_BAR dff_ideal

*// PDLY //*

*// PIN //*

CINA__Input Input_IN_dynamic0 VDD 1.5e-12
CINB__Input Input_IN_dynamic0 GND 1.5e-12
RINA__Input Input_IN_dynamic0 VDD 100000000
RINB__Input Input_IN_dynamic0 GND 100000000
DN__Input GND Input_IN_dynamic0 clamp_diode_1 ; negative clamp
DP__Input Input_IN_dynamic0 VDD clamp_diode_1 ; positive clamp

Enorm__Input A_norm__Input GND VALUE={V(Input_IN_dynamic0,0)/V(VDD,0)}
ABRIDGE-IN__Input [A_norm__Input] [D_norm_del__Input] adc_norm
Xdel__Input D_norm_del__Input D__Input_OUT DELAY_DIST_LUT

* Leakage current at outputs:
R_GreenPOSOUTLEAK Green_OUT_dynamic0 VDD 5e+7
R_GreenNEGOUTLEAK Green_OUT_dynamic0 GND 5e+7
COUTA__Green Green_OUT_dynamic0 VDD 1.5e-12
COUTB__Green Green_OUT_dynamic0 GND 1.5e-12
ROUTA__Green Green_OUT_dynamic0 VDD 100000000
ROUTB__Green Green_OUT_dynamic0 GND 100000000

R_Green_OE A_ONE A__Green_HIZ 1
ABRIDGE-OUT__Green [D__pwm0_OUT0] [A_I__Green] dac_pin_out
EOUT__Green A_OUT_INT__Green GND VALUE = {V(A_I__Green)*V(VDD,GND)}
GOUT__Green Green_OUT_dynamic0 A_OUT_INT__Green VALUE = { V(A_STARTUP)*V(A__Green_HIZ)*(
+ 1*V(A_I__Green)*V(Green_OUT_dynamic0,A_OUT_INT__Green)/V(ROH1X)+
+ 1*(1-V(A_I__Green))*V(Green_OUT_dynamic0,A_OUT_INT__Green)/V(ROL1X)
+ )}

* Leakage current at outputs:
R_RedPOSOUTLEAK Red_OUT_dynamic0 VDD 5e+7
R_RedNEGOUTLEAK Red_OUT_dynamic0 GND 5e+7
COUTA__Red Red_OUT_dynamic0 VDD 1.5e-12
COUTB__Red Red_OUT_dynamic0 GND 1.5e-12
ROUTA__Red Red_OUT_dynamic0 VDD 100000000
ROUTB__Red Red_OUT_dynamic0 GND 100000000

R_Red_OE A_ONE A__Red_HIZ 1
ABRIDGE-OUT__Red [D__pwm1_OUT0] [A_I__Red] dac_pin_out
EOUT__Red A_OUT_INT__Red GND VALUE = {V(A_I__Red)*V(VDD,GND)}
GOUT__Red Red_OUT_dynamic0 A_OUT_INT__Red VALUE = { V(A_STARTUP)*V(A__Red_HIZ)*(
+ 1*V(A_I__Red)*V(Red_OUT_dynamic0,A_OUT_INT__Red)/V(ROH1X)+
+ 1*(1-V(A_I__Red))*V(Red_OUT_dynamic0,A_OUT_INT__Red)/V(ROL1X)
+ )}

* Leakage current at outputs:
R_BluePOSOUTLEAK Blue_OUT_dynamic0 VDD 5e+7
R_BlueNEGOUTLEAK Blue_OUT_dynamic0 GND 5e+7
COUTA__Blue Blue_OUT_dynamic0 VDD 1.5e-12
COUTB__Blue Blue_OUT_dynamic0 GND 1.5e-12
ROUTA__Blue Blue_OUT_dynamic0 VDD 100000000
ROUTB__Blue Blue_OUT_dynamic0 GND 100000000

R_Blue_OE A_ONE A__Blue_HIZ 1
ABRIDGE-OUT__Blue [D__pwm2_OUT0] [A_I__Blue] dac_pin_out
EOUT__Blue A_OUT_INT__Blue GND VALUE = {V(A_I__Blue)*V(VDD,GND)}
GOUT__Blue Blue_OUT_dynamic0 A_OUT_INT__Blue VALUE = { V(A_STARTUP)*V(A__Blue_HIZ)*(
+ 1*V(A_I__Blue)*V(Blue_OUT_dynamic0,A_OUT_INT__Blue)/V(ROH1X)+
+ 1*(1-V(A_I__Blue))*V(Blue_OUT_dynamic0,A_OUT_INT__Blue)/V(ROL1X)
+ )}

* Leakage current at outputs:
R_pin0POSOUTLEAK pin0_OUT_dynamic0 VDD 5e+7
R_pin0NEGOUTLEAK pin0_OUT_dynamic0 GND 5e+7
COUTA__pin0 pin0_OUT_dynamic0 VDD 1.5e-12
COUTB__pin0 pin0_OUT_dynamic0 GND 1.5e-12
ROUTA__pin0 pin0_OUT_dynamic0 VDD 100000000
ROUTB__pin0 pin0_OUT_dynamic0 GND 100000000

R_pin0_OE A_ONE A__pin0_HIZ 1
ABRIDGE-OUT__pin0 [D__Input_OUT] [A_I__pin0] dac_pin_out
EOUT__pin0 A_OUT_INT__pin0 GND VALUE = {V(A_I__pin0)*V(VDD,GND)}
GOUT__pin0 pin0_OUT_dynamic0 A_OUT_INT__pin0 VALUE = { V(A_STARTUP)*V(A__pin0_HIZ)*(
+ 1*V(A_I__pin0)*V(pin0_OUT_dynamic0,A_OUT_INT__pin0)/V(ROH1X)+
+ 1*(1-V(A_I__pin0))*V(pin0_OUT_dynamic0,A_OUT_INT__pin0)/V(ROL1X)
+ )}

*// PIPEDELAY //*

*// POR //*
VSTARTUP A_STARTUP GND PWL(0 0 {1n-1p} 0 1n 1)
ASTARTUP [A_STARTUP] [D_STARTUP] adc_ideal

*// VCC //*
VA_ONE A_ONE GND 1
ABRIDGE_DONE [A_ONE] [D_ONE] adc_ideal
R_VCC0 A__VCC0_OUT VDD 1
ABUF_VCC0 D_ONE D__VCC0_OUT buf_ideal

*// VREF //*

*// WAVE //*

*// Models //*
.model adc_ideal adc_bridge(in_low = 0.5 in_high = 0.5 rise_delay=1e-12 fall_delay=1e-12)
.model dac_ideal dac_bridge(out_low=0 out_high=1 out_undef=0 input_load=1e-15 t_rise=1e-12 t_fall=1e-12)
.model dac_pin_out dac_bridge(out_low=0 out_high=1 out_undef=0 input_load=1e-15 t_rise=1e-8 t_fall=1e-8)
.model buf_ideal d_buffer(rise_delay=1e-12 fall_delay=1e-12 input_load=1e-15)
.model and_ideal d_and(rise_delay=1e-12 fall_delay=1e-12 input_load=1e-15)
.model or_ideal d_or(rise_delay=1e-12 fall_delay=1e-12 input_load=1e-15)
.model inv_ideal d_inverter(rise_delay=1e-12 fall_delay=1e-12 input_load=1e-15)
.model buf_del_1ns d_buffer(rise_delay=1e-9 fall_delay=1e-9 input_load=1e-15)
.model and_del_1ns d_and(rise_delay=1e-9 fall_delay=1e-9 input_load=1e-15)
.model or_del_1ns d_or(rise_delay=1e-9 fall_delay=1e-9 input_load=1e-15)
.model inv_del_1ns d_inverter(rise_delay=1e-9 fall_delay=1e-9 input_load=1e-15)
.model xor_ideal d_xor(rise_delay=1e-12 fall_delay=1e-12 input_load=1e-15)
.model or2_cnt_rst d_or(rise_delay=1e-9 fall_delay=1e-12 input_load=1e-15)
.model xnor_ideal d_xnor(rise_delay=1e-12 fall_delay=1e-12 input_load=1e-15)
.model cnt0_rst_dff d_dff(clk_delay=1e-12 set_delay=1e-12 reset_delay=1e-12 ic=0 rise_delay=1e-12 fall_delay=1e-12)
.model state_8cnt d_state(clk_delay=1e-12 reset_delay=1e-12 state_file="C:\ti\interconnectstudio_1.8.0\product\tools\spice64\lib\common\counter_8bit.in" reset_state=0)
.model hyst_pdly hyst(in_low=0.5 in_high=0.5 hyst={0.19153} out_lower_limit=0 out_upper_limit=1 input_domain=0.01 fraction=TRUE)
.model dff_ideal d_dff(clk_delay=1e-12 set_delay=1e-12 reset_delay=1e-12 ic=0 rise_delay=1e-12 fall_delay=1e-12)
.model adc_norm adc_bridge(in_low = 0.5 in_high = 0.5 rise_delay='1e-9' fall_delay='1e-9')
.model adc_lv_norm adc_bridge(in_low = 0.3 in_high = 0.3 rise_delay='1e-9' fall_delay='1e-9')
.model hyst_norm hyst(in_low=0.5 in_high=0.5 hyst=0.1 out_lower_limit=0 out_upper_limit=1 input_domain=0.01 fraction=TRUE)
.model clamp_diode_1 D (IS=35p RS=64m BV=75 CJO=4p M=0.285 N=1.24)
.ENDS

*// Output and plotting //*

.model dac_ideal dac_bridge(out_low=0 out_high=1 out_undef=0 input_load=1e-15 t_rise=1e-12 t_fall=1e-12)
R_U0_context_Input_IN_EXT EXT_ZERO U0_Input 0
R_U0_context_Green_OUT_EXT Green_OUT_EXT_dynamic0 U0_Green 0
R_U0_context_Red_OUT_EXT Red_OUT_EXT_dynamic0 U0_Red 0
R_U0_context_Blue_OUT_EXT Blue_OUT_EXT_dynamic0 U0_Blue 0

.control
save U0_Input U0_Green U0_Red U0_Blue
tran 9.999999999999999e-6 1e-2 0e+0
* step units: us
* step value: 0.000009999999999999999
plot U0_Input+15 U0_Green+10 U0_Red+5 U0_Blue+0 xlimit 0e+0 1e-2
.endc

*// Sub-circuits required for operation //*
* Nanoseconds - 10 segment distributed delay (up to one full period of delay)
* 7
.SUBCKT DELAY_DIST_LUT IN OUT
.model dist_dly_buff d_buffer(rise_delay = 3.5n fall_delay = 3.5n)
A_out_buff IN OUT dist_dly_buff
.ENDS DELAY_DIST_LUT

.SUBCKT LOGIC_TRI_STATE_OUTPUT IN OUT OEZ VCC VEE
EROH NROH VEE TABLE {V(VCC,VEE)} =
+ (1.8,61)
+ (3.3,50)
+ (5,37)
EROL NROL VEE TABLE {V(VCC,VEE)} =
+ (1.8,18)
+ (3.3,14)
+ (5,9)
EOEZ N2 VEE VALUE = {V(OEZ,VEE)}
E1 N1 VEE VALUE = {V(VCC,VEE)*V(IN,VEE)*V(N2,VEE)}
GOUT N1 OUT VALUE = {V(N1,OUT)*V(N2,VEE)*(V(IN,VEE)/V(NROH,VEE) + (1 - V(IN,VEE))/V(NROL,VEE))}
ROUT OUT VEE 1E8
.ENDS

.SUBCKT SUPPLY_CURRENT VCC VEE
+ PARAMS:
+  ICC = 100n
+  VMAX = 5.5
+  VMIN = 1.65
.PARAM RCC = VMAX/ICC
GICC VCC VEE VALUE = {IF(V(VCC,VEE)<VMIN,1,0)*V(VCC,VEE)/RCC}
.ENDS

.end
