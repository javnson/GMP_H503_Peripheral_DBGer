*// Transient Simulation //*
********************************************************************************
* Mon Oct 12 2026 10:26:32 GMT+0800 (中国标准时间)
*
* Texas Instruments Incorporated
* ASC-INT-LOGIC
* 12500 TI Blvd
* Dallas, TX 75243
*
* Automated model revision history:
* Rev 1.0: [[RELEASE DATE]]
* - Initial version
*
********************************************************************************
*[Disclaimer]
* This model is designed as an aid for customers of Texas Instruments.
* TI and its licensors and suppliers make no warranties, either expressed
* or implied, with respect to this  model, including the warranties of
* merchantability or fitness for a particular purpose. The model is
* provided solely on an "as is" basis. The entire risk as to its quality
* and performance is with the customer.
*
*[Copyright]
*(C) Copyright 2026 Texas Instruments Incorporated. All rights reserved.
********************************************************************************
*// This file generated by InterConnect Studio for simulation with ngspice //*
.include "C:\ti\interconnectstudio_1.8.0\product\source\ti\tpld\.meta\templates\subcircuits\prim_cells_ngspice.mod"
.include "C:\ti\interconnectstudio_1.8.0\product\source\ti\tpld\.meta\templates\subcircuits\dff_ngspice.mod"
.include "C:\ti\interconnectstudio_1.8.0\product\source\ti\tpld\.meta\templates\subcircuits\dff_sr8.mod"
.include "C:\ti\interconnectstudio_1.8.0\product\source\ti\tpld\.meta\templates\subcircuits\dff2_tpld1202.mod"
.include "C:\ti\interconnectstudio_1.8.0\product\source\ti\tpld\.meta\templates\subcircuits\cntr.mod"
.include "C:\ti\interconnectstudio_1.8.0\product\source\ti\tpld\.meta\templates\subcircuits\cntr_dly_1202.mod"
.include "C:\ti\interconnectstudio_1.8.0\product\source\ti\tpld\.meta\templates\subcircuits\pwm.mod"
.include "C:\ti\interconnectstudio_1.8.0\product\source\ti\tpld\.meta\templates\subcircuits\pdly.mod"
.include "C:\ti\interconnectstudio_1.8.0\product\source\ti\tpld\.meta\templates\subcircuits\wdt.mod"
.include "C:\ti\interconnectstudio_1.8.0\product\source\ti\tpld\.meta\templates\subcircuits\asm.mod"
.include "C:\ti\interconnectstudio_1.8.0\product\source\ti\tpld\.meta\templates\subcircuits\pgen.mod"
.include "C:\ti\interconnectstudio_1.8.0\product\source\ti\tpld\.meta\templates\subcircuits\mcacmp.mod"
.func if(a,b,c) 'ternary_fcn( a , b , c )'
.options trtol=1

* system

* CAPACITOR HANDLING

* RESISTOR HANDLING

* INDUCTOR HANDLING

* DIODE HANDLING

* SCHOTTKY DIODE HANDLING

* ZENER DIODE HANDLING

* NPN BJT HANDLING

* PNP BJT HANDLING

* NMOS HANDLING

* PMOS HANDLING

* VOLTAGE SOURCE HANDLING

* CURRENT SOURCE HANDLING

* VCC HANDLING

* TPLD HANDLING

*// Output and plotting //*

.model dac_ideal dac_bridge(out_low=0 out_high=1 out_undef=0 input_load=1e-15 t_rise=1e-12 t_fall=1e-12)

.control
save
tran 9.999999999999999e-6 1e-2 0e+0
* step units: us
* step value: 0.000009999999999999999
plot  xlimit 0e+0 1e-2
.endc

*// Sub-circuits required for operation //*
* Nanoseconds - 10 segment distributed delay (up to one full period of delay)
* 7
.SUBCKT DELAY_DIST_LUT IN OUT
.model dist_dly_buff d_buffer(rise_delay = 3.5n fall_delay = 3.5n)
A_out_buff IN OUT dist_dly_buff
.ENDS DELAY_DIST_LUT

.SUBCKT LOGIC_TRI_STATE_OUTPUT IN OUT OEZ VCC VEE
EROH NROH VEE TABLE {V(VCC,VEE)} =
+ (1.8,61)
+ (3.3,50)
+ (5,37)
EROL NROL VEE TABLE {V(VCC,VEE)} =
+ (1.8,18)
+ (3.3,14)
+ (5,9)
EOEZ N2 VEE VALUE = {V(OEZ,VEE)}
E1 N1 VEE VALUE = {V(VCC,VEE)*V(IN,VEE)*V(N2,VEE)}
GOUT N1 OUT VALUE = {V(N1,OUT)*V(N2,VEE)*(V(IN,VEE)/V(NROH,VEE) + (1 - V(IN,VEE))/V(NROL,VEE))}
ROUT OUT VEE 1E8
.ENDS

.SUBCKT SUPPLY_CURRENT VCC VEE
+ PARAMS:
+  ICC = 100n
+  VMAX = 5.5
+  VMIN = 1.65
.PARAM RCC = VMAX/ICC
GICC VCC VEE VALUE = {IF(V(VCC,VEE)<VMIN,1,0)*V(VCC,VEE)/RCC}
.ENDS

.end
